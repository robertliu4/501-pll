* smoke test: GF180 3.3V nfet/pfet ID at VGS=VDS=3.3
.include /Users/robertliu/.ciel/gf180mcuD/libs.tech/ngspice/design.ngspice
.lib /Users/robertliu/.ciel/gf180mcuD/libs.tech/ngspice/sm141064.ngspice typical
VD d 0 3.3
VG g 0 3.3
M1 d g 0 0 nfet_03v3 W=1u L=0.28u
VDp dp 0 0
VGp gp 0 0
VS s 0 3.3
M2 dp gp s s pfet_03v3 W=1u L=0.28u
.control
op
print -i(VD) i(VDp)
.endc
.end
